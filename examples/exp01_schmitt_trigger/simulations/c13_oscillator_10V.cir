* Circuit 1.3 (procedure part 2) - oscillator with enable, VCC = Vcontrol = 10 V. Booklet figure 1.3.
* Gate A of MC14093: pin 1 = control, pin 2 = capacitor, pin 3 = output; R1 = 10k (3 -> 2), C1 = 0.1 uF (2 -> GND).
* NAND = two switches in series from the output to GND: S1 closes when V(cap) > Vp (with hysteresis),
* S2 closes when the control input is high. Thresholds (datasheet typ): Vp = 5.9 V, Vn = 3.9 V.
* Expected: Vc between 3.9 V and 5.9 V, f = 1233 Hz (full formula; booklet formula gives a few % less).
* Pull-up 1 ohm + switch Ron 1 mohm: charge path = R + 1 ohm and low level ~10 mV, so the
* model adds < 0.1% to the timing (a 100 ohm pull-up had biased f by ~1.6%).
.title Circuit 1.3 oscillator VCC=10V
VDD  vdd 0   DC 10
VCTL ctl 0   DC 10
RPU  vdd out 1
S1   out mid cap 0  SWS
S2   mid 0   ctl 0  SWE
R1   out cap 10k
C1   cap 0   0.1u IC=0
.model SWS SW(Ron=1m Roff=1e9 Vt=4.9 Vh=1)
.model SWE SW(Ron=1m Roff=1e9 Vt=5 Vh=0.1)
.tran 2u 6m UIC
.end
